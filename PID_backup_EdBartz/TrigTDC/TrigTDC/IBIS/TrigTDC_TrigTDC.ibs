| IBIS Models Generator: Lattice Diamond (64-bit) 3.9.0.99.2
| Generate date: Fri Mar 24 12:10:16 2017
| IBIS File ecp3.ibs
| LibisGen v2.0.1.0, 02/25/2008, Lattice Semiconductor Corporation
| Modified by LibisMaker v2.0.1.0, 02/25/2008, Lattice Semiconductor
| Rev 2.1   adds ftBGA256 package model   6/7/10
| North Carolina State University, ERL, 2006
[IBIS ver]   3.2
[File Name]   TrigTDC_TrigTDC.ibs
[File Rev]   2.3
[Date]   Mon Jun 18 11:32:00 EDT 2012
[Source]   Lattice Semiconductor CS200A Process
   LFE3-150EA   FINAL
   Lattice Semiconductor has worked hard to ensure the
   models below are accurate and complete.  However, the
   data below was generated using simulation of the
   input/output model files for the silicon.  Therefore,
   the data below is for reference and initial design
   purposes only.
   Lattice Semiconductor grants permission to use this
   data for use in printed circuit design using this
   Lattice programmable logic device.  Other use of this
   code, including the selling or duplication of any
   portion is strictly prohibited.
|   NAMING CONVENTION
   The IBIS [Model] header is limited by the specification to a
   total of characters.  With such a set of characters available
   for naming models it becomes important to attempt to
   meaningfully encode the IO standards so they fit within the
   twenty character limit.  It would seem that twenty characters
   would provide room enough for describing IO's.  However, the
   PLD IO structure continues to grow more and more complex.  The
   complexity is making the twenty characters insuffiently
   descriptive.  In order to overcome this issue the naming
   convention described below is implemented to resolve the issue.
The twenty character space is managed as follows:
   bbbvvvsdddprugtmoixx
   b = standard
   v = voltage (x.xx V)
   s = slew code
   d = drive (xx.x ma)
   p = pullup code
   r = series resistance code
   u = terminate to vcc code
   g = terminate to gnd code
   t = terminate to vtt code
   m = multdrive
   o = diff resistor code
   i = diffdrive
   x = reserved
   standard
   LVCMOS   lvc
   lvcmosd   lvd
   LVDSE   lve
   LVTTL   lvt
   lvttld   ltd
   PCI   pci
   sstl   ss1
   sstl_I   ss1
   sstl_II   ss2
   sstld   s1d
   sstld_I   s1d
   sstld_II   s2d
   CTT   ctt
   hstl_i   hs1
   hstl_ii   hs2
   hstld_i   h1d
   hstld_ii   h2d
   lvds   lvs
   blvds   blv
   mlvds   mlv
   lvpecl   lvp
   hypt   hyp
   rsds   rsd
   rsdse   rse
   pplvds   psd
   minilvds   mnl
   vref1   vr1
   vref2   vr2
   ref_res   rer
   slew
   na   a
   fast   f
   slow   s
   pullmode
   off   a
   pullup   b
   pulldown   c
   bushold   d
   pciclamp   e
   up_pciclamp   f
   down_pciclamp   g
   keeper_pciclamp   h
   impedance
   off   a
   25   b
   33   c
   50   d
   100   e
   termVCC
   off   a
   50   b
   75   c
   120   d
   termGND
   off   a
   50   b
   75   c
   120   d
   termVTT
   off   a
   40   b
   50   c
   60   d
   multi drive
   NA   a
   2x   b
   3x   c
   4x   d
   differential resistor
   off   a
   80   b
   100   c
   120   d
   diff drive
   NA   a
   2.0   b
   1.93   c
   1.87   d
   1.81   e
   1.75   f
   1.7   g
   1.65   h
   1.6   i
   Reserved   IO type
   in   input only
   ou   output
   io   I/O
   od   Open drain
   on   Inverting differential I/O
   (signal name only)
   op   Non-Inverting differential I/O
   (signal name only)
   All the IO models are generated with pull mode set to UP.
   Lattice Semiconductor Corporation
   5555 NE Moore Court
   Hillsboro, OR 97214
   U.S.A
   TEL: 1-800-Lattice (USA and Canada)
   408-826-6000 (other locations)
   web: http://www.latticesemi.com/
   email: techsupport@latticesemi.com
[Disclaimer] This IBIS source code is intended as a design reference
   which illustrates how the Lattice Semiconductor device operates.
   It is the user's responsibility to verify their design for
   consistency and functionality through the use of formal
   verification methods.  Lattice Semiconductor provides no warranty
   regarding the use or functionality of this data.
[Copyright]   Copyright 2007 by Lattice Semiconductor Corporation
|   Component ECP3
[Component]   ECP3
[Manufacturer]   Lattice Semiconductor Corp.
[Package]
|FPBGA672
| variable   typ   min   max
R_pkg   247.00m   124.00m   273.00m
L_pkg   7.31nH   3.83nH   9.10nH
C_pkg   1.70pF   1.12pF   2.32pF
[Pin] signal_name   model_name   R_pin   L_pin   C_pin
P1   INP[0]+   lvs250fxxxeaaaaaaain
P2   INP[0]-   lvs250fxxxeaaaaaaain
Y5   INP[10]+   lvs250fxxxeaaaaaaain
AA5   INP[10]-   lvs250fxxxeaaaaaaain
V6   INP[11]+   lvs250fxxxeaaaaaaain
V7   INP[11]-   lvs250fxxxeaaaaaaain
H2   INP[12]+   lvs250fxxxeaaaaaaain
G1   INP[12]-   lvs250fxxxeaaaaaaain
H1   INP[13]+   lvs250fxxxeaaaaaaain
J1   INP[13]-   lvs250fxxxeaaaaaaain
M5   INP[14]+   lvs250fxxxeaaaaaaain
M6   INP[14]-   lvs250fxxxeaaaaaaain
L2   INP[15]+   lvs250fxxxeaaaaaaain
L1   INP[15]-   lvs250fxxxeaaaaaaain
AD1   INP[16]+   lvs250fxxxeaaaaaaain
AD2   INP[16]-   lvs250fxxxeaaaaaaain
AB5   INP[17]+   lvs250fxxxeaaaaaaain
AB6   INP[17]-   lvs250fxxxeaaaaaaain
AB3   INP[18]+   lvs250fxxxeaaaaaaain
AB4   INP[18]-   lvs250fxxxeaaaaaaain
Y6   INP[19]+   lvs250fxxxeaaaaaaain
Y7   INP[19]-   lvs250fxxxeaaaaaaain
T2   INP[1]+   lvs250fxxxeaaaaaaain
U3   INP[1]-   lvs250fxxxeaaaaaaain
AA3   INP[20]+   lvs250fxxxeaaaaaaain
AA4   INP[20]-   lvs250fxxxeaaaaaaain
W8   INP[21]+   lvs250fxxxeaaaaaaain
W9   INP[21]-   lvs250fxxxeaaaaaaain
V1   INP[22]+   lvs250fxxxeaaaaaaain
U2   INP[22]-   lvs250fxxxeaaaaaaain
T1   INP[23]+   lvs250fxxxeaaaaaaain
U1   INP[23]-   lvs250fxxxeaaaaaaain
P4   INP[24]+   lvs250fxxxeaaaaaaain
R3   INP[24]-   lvs250fxxxeaaaaaaain
T3   INP[25]+   lvs250fxxxeaaaaaaain
R4   INP[25]-   lvs250fxxxeaaaaaaain
R5   INP[26]+   lvs250fxxxeaaaaaaain
R6   INP[26]-   lvs250fxxxeaaaaaaain
T7   INP[27]+   lvs250fxxxeaaaaaaain
T8   INP[27]-   lvs250fxxxeaaaaaaain
K2   INP[28]+   lvs250fxxxeaaaaaaain
K1   INP[28]-   lvs250fxxxeaaaaaaain
K4   INP[29]+   lvs250fxxxeaaaaaaain
K5   INP[29]-   lvs250fxxxeaaaaaaain
R1   INP[2]+   lvs250fxxxeaaaaaaain
R2   INP[2]-   lvs250fxxxeaaaaaaain
E1   INP[30]+   lvs250fxxxeaaaaaaain
F1   INP[30]-   lvs250fxxxeaaaaaaain
B2   INP[31]+   lvs250fxxxeaaaaaaain
B3   INP[31]-   lvs250fxxxeaaaaaaain
J23   INP[32]+   lvs250fxxxeaaaaaaain
H23   INP[32]-   lvs250fxxxeaaaaaaain
G26   INP[33]+   lvs250fxxxeaaaaaaain
F26   INP[33]-   lvs250fxxxeaaaaaaain
F24   INP[34]+   lvs250fxxxeaaaaaaain
G24   INP[34]-   lvs250fxxxeaaaaaaain
H26   INP[35]+   lvs250fxxxeaaaaaaain
H25   INP[35]-   lvs250fxxxeaaaaaaain
K23   INP[36]+   lvs250fxxxeaaaaaaain
K22   INP[36]-   lvs250fxxxeaaaaaaain
F25   INP[37]+   lvs250fxxxeaaaaaaain
E26   INP[37]-   lvs250fxxxeaaaaaaain
AC26   INP[38]+   lvs250fxxxeaaaaaaain
AC25   INP[38]-   lvs250fxxxeaaaaaaain
Y19   INP[39]+   lvs250fxxxeaaaaaaain
Y20   INP[39]-   lvs250fxxxeaaaaaaain
N3   INP[3]+   lvs250fxxxeaaaaaaain
P3   INP[3]-   lvs250fxxxeaaaaaaain
AB24   INP[40]+   lvs250fxxxeaaaaaaain
AC24   INP[40]-   lvs250fxxxeaaaaaaain
Y22   INP[41]+   lvs250fxxxeaaaaaaain
AA22   INP[41]-   lvs250fxxxeaaaaaaain
AD24   INP[42]+   lvs250fxxxeaaaaaaain
AE24   INP[42]-   lvs250fxxxeaaaaaaain
AE25   INP[43]+   lvs250fxxxeaaaaaaain
AF24   INP[43]-   lvs250fxxxeaaaaaaain
W23   INP[44]+   lvs250fxxxeaaaaaaain
W22   INP[44]-   lvs250fxxxeaaaaaaain
AA25   INP[45]+   lvs250fxxxeaaaaaaain
Y24   INP[45]-   lvs250fxxxeaaaaaaain
AA26   INP[46]+   lvs250fxxxeaaaaaaain
AB26   INP[46]-   lvs250fxxxeaaaaaaain
W21   INP[47]+   lvs250fxxxeaaaaaaain
W20   INP[47]-   lvs250fxxxeaaaaaaain
P5   INP[4]+   lvs250fxxxeaaaaaaain
P6   INP[4]-   lvs250fxxxeaaaaaaain
N5   INP[5]+   lvs250fxxxeaaaaaaain
N6   INP[5]-   lvs250fxxxeaaaaaaain
AC2   INP[6]+   lvs250fxxxeaaaaaaain
AC3   INP[6]-   lvs250fxxxeaaaaaaain
AB1   INP[7]+   lvs250fxxxeaaaaaaain
AC1   INP[7]-   lvs250fxxxeaaaaaaain
AA1   INP[8]+   lvs250fxxxeaaaaaaain
AA2   INP[8]-   lvs250fxxxeaaaaaaain
W7   INP[9]+   lvs250fxxxeaaaaaaain
W6   INP[9]-   lvs250fxxxeaaaaaaain
F12   LED_GREEN   lvc250s120eaaaaaaaou
G13   LED_ORANGE   lvc250s120eaaaaaaaou
A15   LED_RED   lvc250s120eaaaaaaaou
A16   LED_YELLOW   lvc250s120eaaaaaaaou
W1   MCLK   lvc250fxxxfaaaaaaain
K3   OUT_pA[0]+   lvs250sxxxeaaaabafou
L3   OUT_pA[0]-   lvs250sxxxeaaaabafou
J4   OUT_pA[1]+   lvs250sxxxeaaaabafou
J3   OUT_pA[1]-   lvs250sxxxeaaaabafou
D1   OUT_pA[2]+   lvs250sxxxeaaaabafou
C1   OUT_pA[2]-   lvs250sxxxeaaaabafou
F2   OUT_pB[0]+   lvs250sxxxeaaaabafou
F3   OUT_pB[0]-   lvs250sxxxeaaaabafou
D4   OUT_pB[1]+   lvs250sxxxeaaaabafou
E4   OUT_pB[1]-   lvs250sxxxeaaaabafou
H6   OUT_pB[2]+   lvs250sxxxeaaaabafou
J6   OUT_pB[2]-   lvs250sxxxeaaaabafou
P21   OUT_pC[0]+   lvs250sxxxeaaaabafou
P22   OUT_pC[0]-   lvs250sxxxeaaaabafou
N23   OUT_pC[1]+   lvs250sxxxeaaaabafou
N22   OUT_pC[1]-   lvs250sxxxeaaaabafou
H5   OUT_pC[2]+   lvs250sxxxeaaaabafou
J5   OUT_pC[2]-   lvs250sxxxeaaaabafou
C3   OUT_pD[0]+   lvs250sxxxeaaaabafou
D3   OUT_pD[0]-   lvs250sxxxeaaaabafou
L5   OUT_pD[1]+   lvs250sxxxeaaaabafou
L6   OUT_pD[1]-   lvs250sxxxeaaaabafou
K8   TestIn[12]   lvc250fxxxgaaaaaaain
J7   TestIn[13]   lvc250fxxxgaaaaaaain
H24   TestLED[0]   lvc250s120eaaaaaaaou
G25   TestLED[1]   lvc250s120eaaaaaaaou
L20   TestLED[2]   lvc250s120eaaaaaaaou
M21   TestLED[3]   lvc250s120eaaaaaaaou
K24   TestLED[4]   lvc250s120eaaaaaaaou
J24   TestLED[5]   lvc250s120eaaaaaaaou
M23   TestLED[6]   lvc250s120eaaaaaaaou
M24   TestLED[7]   lvc250s120eaaaaaaaou
L24   TestOut[0]   lvc250s120eaaaaaaaou
T25   TestOut[10]   lvc250s120eaaaaaaaou
T24   TestOut[11]   lvc250s120eaaaaaaaou
K25   TestOut[1]   lvc250s120eaaaaaaaou
M22   TestOut[2]   lvc250s120eaaaaaaaou
N21   TestOut[3]   lvc250s120eaaaaaaaou
K19   TestOut[4]   lvc250s120eaaaaaaaou
L19   TestOut[5]   lvc250s120eaaaaaaaou
P23   TestOut[6]   lvc250s120eaaaaaaaou
R22   TestOut[7]   lvc250s120eaaaaaaaou
R25   TestOut[8]   lvc250s120eaaaaaaaou
R26   TestOut[9]   lvc250s120eaaaaaaaou
[Diff pin]  inv_pin  vdiff  tdelay_typ  tdelay_min  tdelay_max
K3   L3   0.1   0.0s   0.0s   0.0s
J4   J3   0.1   0.0s   0.0s   0.0s
D1   C1   0.1   0.0s   0.0s   0.0s
F2   F3   0.1   0.0s   0.0s   0.0s
D4   E4   0.1   0.0s   0.0s   0.0s
H6   J6   0.1   0.0s   0.0s   0.0s
P21   P22   0.1   0.0s   0.0s   0.0s
N23   N22   0.1   0.0s   0.0s   0.0s
H5   J5   0.1   0.0s   0.0s   0.0s
C3   D3   0.1   0.0s   0.0s   0.0s
L5   L6   0.1   0.0s   0.0s   0.0s
| Models and submodels in the file (5): lvc250fxxxfaaaaaaain (Input), lvc250fxxxgaaaaaaain (Input), lvc250s120eaaaaaaaou (Output), lvs250fxxxeaaaaaaain (Input), lvs250sxxxeaaaabafou (Output)
